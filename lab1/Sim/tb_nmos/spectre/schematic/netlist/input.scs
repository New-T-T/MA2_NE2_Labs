// Design: NE2/tb_nmos
simulator lang=spectre
global 0
parameters vds=1.8 vgs=200m
include "/usr/pack/xfab-180-mp/xp018/cadence/v6_1/spectre/v6_1_5/lp5mos/config.scs" section=default
include "/usr/pack/xfab-180-mp/xp018/cadence/v6_1/spectre/v6_1_5/lp5mos/param.scs" section=3s
include "/usr/pack/xfab-180-mp/xp018/cadence/v6_1/spectre/v6_1_5/lp5mos/bip.scs" section=tm
include "/usr/pack/xfab-180-mp/xp018/cadence/v6_1/spectre/v6_1_5/lp5mos/cap.scs" section=tm
include "/usr/pack/xfab-180-mp/xp018/cadence/v6_1/spectre/v6_1_5/lp5mos/dio.scs" section=tm
include "/usr/pack/xfab-180-mp/xp018/cadence/v6_1/spectre/v6_1_5/lp5mos/mos.scs" section=tm
include "/usr/pack/xfab-180-mp/xp018/cadence/v6_1/spectre/v6_1_5/lp5mos/res.scs" section=tm

// NE2/tb_nmos/schematic
M0 (Vds Vgs 0 0) ne w=2u l=180.0n m=(1)*(1)
V1 (Vgs 0) vsource dc=vgs type=dc
V0 (Vds 0) vsource dc=vds type=dc
simulatorOptions options reltol=100e-6 temp=27 homotopy=all limit=delta compatible=spice2 gmin=1e-15
dc dc param=vds start=0 stop=1.8
save M0:1
